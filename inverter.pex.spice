* PEX produced on Sun Feb  2 08:21:58 PM CET 2025 using /foss/tools/osic-multitool/iic-pex.sh with m=3 and s=1
* NGSPICE file created from inverter.ext - technology: sky130A

.subckt inverter VP A Y VN
X0 Y.t1 A.t0 VP.t1 VP.t0 sky130_fd_pr__pfet_01v8 ad=0.3 pd=2.6 as=0.3 ps=2.6 w=1 l=0.15
X1 Y.t0 A.t1 VN.t1 VN.t0 sky130_fd_pr__nfet_01v8 ad=0.3 pd=2.6 as=0.3 ps=2.6 w=1 l=0.15
R0 A A.t0 416.236
R1 A A.t1 416.019
R2 VP.n16 VP.n10 681.178
R3 VP.n29 VP.n24 681.178
R4 VP.n33 VP.n23 681.178
R5 VP.n19 VP.n8 681.178
R6 VP.n42 VP.t1 356.565
R7 VP.n16 VP.n2 254.119
R8 VP.n39 VP.n2 254.119
R9 VP.n39 VP.n3 254.119
R10 VP.n24 VP.n3 254.119
R11 VP.n25 VP.n23 254.119
R12 VP.n19 VP.n5 254.119
R13 VP.n37 VP.n5 254.119
R14 VP.n37 VP.n6 254.119
R15 VP.n33 VP.n6 254.119
R16 VP.n12 VP.n8 254.119
R17 VP.n18 VP.n9 185.232
R18 VP.n32 VP.n31 185.232
R19 VP.n8 VP.n7 185
R20 VP.n9 VP.n8 185
R21 VP.n13 VP.n12 185
R22 VP.n14 VP.n10 185
R23 VP.n34 VP.n33 185
R24 VP.n33 VP.n32 185
R25 VP.n35 VP.n6 185
R26 VP.n6 VP.n4 185
R27 VP.n37 VP.n36 185
R28 VP.n38 VP.n37 185
R29 VP.n21 VP.n5 185
R30 VP.n17 VP.n5 185
R31 VP.n20 VP.n19 185
R32 VP.n19 VP.n18 185
R33 VP.n29 VP.n28 185
R34 VP.n26 VP.n25 185
R35 VP.n23 VP.n22 185
R36 VP.n31 VP.n23 185
R37 VP.n16 VP.n15 185
R38 VP.n18 VP.n16 185
R39 VP.n2 VP.n0 185
R40 VP.n17 VP.n2 185
R41 VP.n40 VP.n39 185
R42 VP.n39 VP.n38 185
R43 VP.n3 VP.n1 185
R44 VP.n4 VP.n3 185
R45 VP.n27 VP.n24 185
R46 VP.n32 VP.n24 185
R47 VP.n18 VP.n17 132.047
R48 VP.n38 VP.n4 132.047
R49 VP.n32 VP.n4 132.047
R50 VP.n30 VP.n29 75.3262
R51 VP.n12 VP.n11 75.3262
R52 VP.n11 VP.n10 75.3262
R53 VP.n30 VP.n25 75.3262
R54 VP.n20 VP.n7 72.6593
R55 VP.n34 VP.n22 72.6593
R56 VP.n17 VP.t0 69.6916
R57 VP.n38 VP.t0 62.3557
R58 VP.n11 VP.n9 54.8384
R59 VP.n31 VP.n30 54.8384
R60 VP.n15 VP.n14 37.1315
R61 VP.n28 VP.n27 37.1315
R62 VP.n13 VP.n7 27.1064
R63 VP.n14 VP.n13 27.1064
R64 VP.n21 VP.n20 27.1064
R65 VP.n36 VP.n21 27.1064
R66 VP.n36 VP.n35 27.1064
R67 VP.n35 VP.n34 27.1064
R68 VP.n26 VP.n22 27.1064
R69 VP.n28 VP.n26 27.1064
R70 VP.n42 VP.n41 3.08112
R71 VP.n15 VP.n0 1.77965
R72 VP.n40 VP.n1 1.77965
R73 VP.n27 VP.n1 1.77965
R74 VP.n41 VP.n0 1.03834
R75 VP.n41 VP.n40 0.741813
R76 VP VP.n42 0.255275
R77 Y Y.t1 357.693
R78 Y Y.t0 134.337
R79 VN.n17 VN.n10 1118.26
R80 VN.n30 VN.n3 1118.26
R81 VN.n33 VN.n6 1118.26
R82 VN.n14 VN.n8 1118.26
R83 VN.n14 VN.n13 585
R84 VN.n15 VN.n14 585
R85 VN.n12 VN.n11 585
R86 VN.n18 VN.n17 585
R87 VN.n35 VN.n6 585
R88 VN.n6 VN.n4 585
R89 VN.n37 VN.n36 585
R90 VN.n38 VN.n37 585
R91 VN.n26 VN.n5 585
R92 VN.n22 VN.n5 585
R93 VN.n25 VN.n24 585
R94 VN.n24 VN.n23 585
R95 VN.n8 VN.n7 585
R96 VN.n9 VN.n8 585
R97 VN.n30 VN.n29 585
R98 VN.n28 VN.n27 585
R99 VN.n34 VN.n33 585
R100 VN.n33 VN.n32 585
R101 VN.n19 VN.n10 585
R102 VN.n10 VN.n9 585
R103 VN.n21 VN.n20 585
R104 VN.n23 VN.n21 585
R105 VN.n2 VN.n0 585
R106 VN.n22 VN.n2 585
R107 VN.n40 VN.n39 585
R108 VN.n39 VN.n38 585
R109 VN.n3 VN.n1 585
R110 VN.n4 VN.n3 585
R111 VN.n21 VN.n10 417.176
R112 VN.n21 VN.n2 417.176
R113 VN.n39 VN.n2 417.176
R114 VN.n39 VN.n3 417.176
R115 VN.n33 VN.n28 417.176
R116 VN.n24 VN.n8 417.176
R117 VN.n24 VN.n5 417.176
R118 VN.n37 VN.n5 417.176
R119 VN.n37 VN.n6 417.176
R120 VN.n14 VN.n12 417.176
R121 VN.n15 VN.n9 346.916
R122 VN.n32 VN.n4 346.916
R123 VN.n23 VN.n9 247.308
R124 VN.n23 VN.n22 247.308
R125 VN.n38 VN.n4 247.308
R126 VN.n16 VN.n15 215.619
R127 VN.n32 VN.n31 215.619
R128 VN.n31 VN.n30 153.763
R129 VN.n16 VN.n12 153.763
R130 VN.n17 VN.n16 153.763
R131 VN.n31 VN.n28 153.763
R132 VN.n42 VN.t1 133.498
R133 VN.n38 VN.t0 130.524
R134 VN.n22 VN.t0 116.784
R135 VN.n13 VN.n7 72.6593
R136 VN.n35 VN.n34 72.6593
R137 VN.n19 VN.n18 34.7318
R138 VN.n29 VN.n1 34.7318
R139 VN.n13 VN.n11 27.1064
R140 VN.n18 VN.n11 27.1064
R141 VN.n25 VN.n7 27.1064
R142 VN.n26 VN.n25 27.1064
R143 VN.n36 VN.n26 27.1064
R144 VN.n36 VN.n35 27.1064
R145 VN.n34 VN.n27 27.1064
R146 VN.n29 VN.n27 27.1064
R147 VN.n42 VN.n41 3.07839
R148 VN.n20 VN.n19 1.67919
R149 VN.n20 VN.n0 1.67919
R150 VN.n40 VN.n1 1.67919
R151 VN.n41 VN.n0 0.886474
R152 VN.n41 VN.n40 0.793214
R153 VN VN.n42 0.323957
C0 A Y 0.088322f
C1 VP Y 0.275209f
C2 A VP 0.243949f
C3 Y VN 0.78347f
C4 A VN 0.440946f
C5 VP VN 2.09803f
.ends
