** sch_path: /foss/designs/SKY/inverter/inverter_tb_dc.sch
.subckt inverter_tb_dc Vout
*.PININFO Vout:O
Vdd Vdd GND 1.8
Vin Vin GND 0
x1 Vdd Vin Vout GND inverter
**** begin user architecture code

** opencircuitdesign pdks install
.lib /foss/pdks/sky130A/libs.tech/combined/sky130.lib.spice tt

.save all
.control

dc Vin 0 1.8 0.01
plot v(Vin) v(Vout)
.endc

**** end user architecture code
.ends
.GLOBAL GND
.end
